; Default CDF Data for NCSU_Devices_FreePDK45 (Schematics)
loadi( strcat( getShellEnvVar("PDK_DIR") "/ncsu_basekit/skill/cdf/NMOS_THKOX.il"))
loadi( strcat( getShellEnvVar("PDK_DIR") "/ncsu_basekit/skill/cdf/NMOS_VTG.il"))
loadi( strcat( getShellEnvVar("PDK_DIR") "/ncsu_basekit/skill/cdf/NMOS_VTH.il"))
loadi( strcat( getShellEnvVar("PDK_DIR") "/ncsu_basekit/skill/cdf/NMOS_VTL.il"))
loadi( strcat( getShellEnvVar("PDK_DIR") "/ncsu_basekit/skill/cdf/PMOS_THKOX.il"))
loadi( strcat( getShellEnvVar("PDK_DIR") "/ncsu_basekit/skill/cdf/PMOS_VTG.il"))
loadi( strcat( getShellEnvVar("PDK_DIR") "/ncsu_basekit/skill/cdf/PMOS_VTH.il"))
loadi( strcat( getShellEnvVar("PDK_DIR") "/ncsu_basekit/skill/cdf/PMOS_VTL.il"))
